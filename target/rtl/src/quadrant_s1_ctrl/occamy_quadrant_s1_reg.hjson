// Copyright 2020 ETH Zurich and University of Bologna.
// Solderpad Hardware License, Version 0.51, see LICENSE for details.
// SPDX-License-Identifier: SHL-0.51
// Licensed under Solderpad Hardware License, Version 0.51, see LICENSE for details.
{
  name: "occamy_quadrant_s1",
  clock_primary: "clk_i",
  bus_interfaces: [
    { protocol: "reg_iface", direction: "device" }
  ],
  regwidth: 32,
  registers: [

    { name: "CLK_ENA",
      desc: "Quadrant-internal clock gate enable",
      swaccess: "rw",
      hwaccess: "hro",
      // Clock disabled (i.e. gated) by default
      fields: [
        {bits: "0:0", name: "ena_cluster_0", resval: 0, desc: "Clock gate enable for cluster 0"},
        {bits: "1:1", name: "ena_cluster_1", resval: 0, desc: "Clock gate enable for cluster 1"},
        {bits: "2:2", name: "ena_cluster_2", resval: 0, desc: "Clock gate enable for cluster 2"},
        {bits: "3:3", name: "ena_cluster_3", resval: 0, desc: "Clock gate enable for cluster 3"},
        {bits: "4:4", name: "ena_quad_uncore",  resval: 0, desc: "Clock gate enable for cluster un-core"}
      ],
    },
    { name: "RESET_N",
      desc: "Quadrant-internal asynchronous active-low reset",
      swaccess: "rw",
      hwaccess: "hro",
      // *Not* held in reset (i.e. signal high) by default.
      // Since clock is gated on reset, inner quadrant state should *not* change until ungate.
      fields: [
        {bits: "0:0", name: "reset_n", resval: 1, desc: "Asynchronous active-low reset"}
      ]
    },
    { name: "ISOLATE",
      desc: "Isolate ports of given quadrant.",
      swaccess: "rw",
      hwaccess: "hro",
      // All channels isolated by default
      fields: [
        {bits: "0:0", name: "narrow_in",  resval: 1, desc: "narrow slave in isolate"},
        {bits: "1:1", name: "narrow_out", resval: 1, desc: "narrow master out isolate"},
        {bits: "2:2", name: "wide_in",    resval: 1, desc: "wide slave in isolate"},
        {bits: "3:3", name: "wide_out",   resval: 1, desc: "wide master out isolate"}
      ]
    },
    { name: "ISOLATED"
      desc: "Isolation status of S1 quadrant and port"
      swaccess: "ro"
      hwaccess: "hwo"
      hwqe: "true",
      hwext: "true",
      // All channels isolated by default
      fields: [
        {bits: "0:0", name: "narrow_in",  resval: 1, desc: "narrow slave in isolation status"},
        {bits: "1:1", name: "narrow_out", resval: 1, desc: "narrow master out isolation status"},
        {bits: "2:2", name: "wide_in",    resval: 1, desc: "wide slave in isolation status"},
        {bits: "3:3", name: "wide_out",   resval: 1, desc: "wide master out isolation status"}
      ]
    },
#// TODO: The enable registers below are unconditionally present; conditionalize on config?
    { name: "RO_CACHE_ENABLE",
      desc: "Enable read-only cache of quadrant.",
      swaccess: "rw",
      hwaccess: "hro",
      fields: [
        { bits: "0:0", resval: 0, name: "enable", desc: "Enable RO cache of S1 quadrant."}
      ]
    },
    { name: "RO_CACHE_FLUSH",
      desc: "Flush read-only cache.",
      swaccess: "rw"
      hwaccess: "hrw"
      fields: [
        { bits: "0:0", resval: 0, name: "flush", desc: "Flush (invalidate) RO cache of S1 quadrant."}
      ]
    },
    { name: "TLB_WIDE_ENABLE",
      desc: "Enable TLB on wide interface of quadrant.",
      swaccess: "rw",
      hwaccess: "hro",
      fields: [
        { bits: "0:0", resval: 0, name: "enable", desc: "Enable TLB on {t} interface."}
      ]
    },
    { name: "TLB_NARROW_ENABLE",
      desc: "Enable TLB on narrow interface of quadrant.",
      swaccess: "rw",
      hwaccess: "hro",
      fields: [
        { bits: "0:0", resval: 0, name: "enable", desc: "Enable TLB on {t} interface."}
      ]
    },

    // Start RO cache region fields at regular offset
    { skipto: "0x100" }
    { name: "RO_START_ADDR_LOW_0",
      desc: "Read-only cache start address low",
      swaccess: "rw",
      hwaccess: "hro",
      fields: [
        {bits: "31:0", name: "ADDR_LOW", desc: "Lower 32-bit of read-only region."}
      ]
    },
    { name: "RO_START_ADDR_HIGH_0",
      desc: "Read-only cache start address high",
      swaccess: "rw",
      hwaccess: "hro",
      fields: [
        {bits: "15:0", name: "ADDR_HIGH", resval: 0, desc: "Higher 32-bit of read-only region."}
      ]
    }
    { name: "RO_END_ADDR_LOW_0",
      desc: "Read-only cache end address low",
      swaccess: "rw",
      hwaccess: "hro",
      fields: [
        {bits: "31:0", name: "ADDR_LOW", desc: "Lower 32-bit of read-only region."}
      ]
    },
    { name: "RO_END_ADDR_HIGH_0",
      desc: "Read-only cache end address high",
      swaccess: "rw",
      hwaccess: "hro",
      fields: [
        {bits: "15:0", name: "ADDR_HIGH", resval: 1, desc: "Higher 32-bit of read-only region."}
      ]
    }
    { name: "RO_START_ADDR_LOW_1",
      desc: "Read-only cache start address low",
      swaccess: "rw",
      hwaccess: "hro",
      fields: [
        {bits: "31:0", name: "ADDR_LOW", desc: "Lower 32-bit of read-only region."}
      ]
    },
    { name: "RO_START_ADDR_HIGH_1",
      desc: "Read-only cache start address high",
      swaccess: "rw",
      hwaccess: "hro",
      fields: [
        {bits: "15:0", name: "ADDR_HIGH", resval: 1, desc: "Higher 32-bit of read-only region."}
      ]
    }
    { name: "RO_END_ADDR_LOW_1",
      desc: "Read-only cache end address low",
      swaccess: "rw",
      hwaccess: "hro",
      fields: [
        {bits: "31:0", name: "ADDR_LOW", desc: "Lower 32-bit of read-only region."}
      ]
    },
    { name: "RO_END_ADDR_HIGH_1",
      desc: "Read-only cache end address high",
      swaccess: "rw",
      hwaccess: "hro",
      fields: [
        {bits: "15:0", name: "ADDR_HIGH", resval: 2, desc: "Higher 32-bit of read-only region."}
      ]
    }
    { name: "RO_START_ADDR_LOW_2",
      desc: "Read-only cache start address low",
      swaccess: "rw",
      hwaccess: "hro",
      fields: [
        {bits: "31:0", name: "ADDR_LOW", desc: "Lower 32-bit of read-only region."}
      ]
    },
    { name: "RO_START_ADDR_HIGH_2",
      desc: "Read-only cache start address high",
      swaccess: "rw",
      hwaccess: "hro",
      fields: [
        {bits: "15:0", name: "ADDR_HIGH", resval: 2, desc: "Higher 32-bit of read-only region."}
      ]
    }
    { name: "RO_END_ADDR_LOW_2",
      desc: "Read-only cache end address low",
      swaccess: "rw",
      hwaccess: "hro",
      fields: [
        {bits: "31:0", name: "ADDR_LOW", desc: "Lower 32-bit of read-only region."}
      ]
    },
    { name: "RO_END_ADDR_HIGH_2",
      desc: "Read-only cache end address high",
      swaccess: "rw",
      hwaccess: "hro",
      fields: [
        {bits: "15:0", name: "ADDR_HIGH", resval: 3, desc: "Higher 32-bit of read-only region."}
      ]
    }
    { name: "RO_START_ADDR_LOW_3",
      desc: "Read-only cache start address low",
      swaccess: "rw",
      hwaccess: "hro",
      fields: [
        {bits: "31:0", name: "ADDR_LOW", desc: "Lower 32-bit of read-only region."}
      ]
    },
    { name: "RO_START_ADDR_HIGH_3",
      desc: "Read-only cache start address high",
      swaccess: "rw",
      hwaccess: "hro",
      fields: [
        {bits: "15:0", name: "ADDR_HIGH", resval: 3, desc: "Higher 32-bit of read-only region."}
      ]
    }
    { name: "RO_END_ADDR_LOW_3",
      desc: "Read-only cache end address low",
      swaccess: "rw",
      hwaccess: "hro",
      fields: [
        {bits: "31:0", name: "ADDR_LOW", desc: "Lower 32-bit of read-only region."}
      ]
    },
    { name: "RO_END_ADDR_HIGH_3",
      desc: "Read-only cache end address high",
      swaccess: "rw",
      hwaccess: "hro",
      fields: [
        {bits: "15:0", name: "ADDR_HIGH", resval: 4, desc: "Higher 32-bit of read-only region."}
      ]
    }

  ]
}
